** Profile: "SCHEMATIC1-sim1"  [ c:\users\lfbarrag\documents\slugsat\github\schematics_pcbs\lt\29.4mhz low-pass filter\29mhz-lpf-pspicefiles\schematic1\sim1.sim ]

** Creating circuit file "sim1.cir"
** WARNING: THIS AUTOMATICALLY GENERATED FILE MAY BE OVERWRITTEN BY SUBSEQUENT SIMULATIONS

*Libraries:
* Profile Libraries :
* Local Libraries :
* From [PSPICE NETLIST] section of C:\Users\lfbarrag\cdssetup\OrCAD_PSpice\17.2.0\PSpice.ini file:
.lib "nomd.lib"

*Analysis directives:
.AC DEC 10000 15E6 80E6
.OPTIONS ADVCONV
.PROBE64 V(alias(*)) I(alias(*)) W(alias(*)) D(alias(*)) NOISE(alias(*))
.INC "..\SCHEMATIC1.net"

.END
